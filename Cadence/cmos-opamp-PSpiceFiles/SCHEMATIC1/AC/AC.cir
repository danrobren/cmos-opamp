** Profile: "SCHEMATIC1-AC"  [ D:\Documents\Joshua\2025-26\Spring Sem\325\Final Proj\cmos-opamp-JOSHHHH\cmos-opamp-JOSHHHH\Cadence\cmos-opamp-pspicefiles\schematic1\ac.sim ]

** Creating circuit file "AC.cir"
** WARNING: THIS AUTOMATICALLY GENERATED FILE MAY BE OVERWRITTEN BY SUBSEQUENT SIMULATIONS

*Libraries:
* Profile Libraries :
* Local Libraries :
.LIB "../../../mosfet.lib"
* From [PSPICE NETLIST] section of D:\Documents\Joshua\cdssetup\OrCAD_PSpice\25.1.0\PSpice.ini file:
.lib "nom.lib"

*Analysis directives:
.AC DEC 20 1 10Meg
.OPTIONS ADVCONV
.PROBE64 V(alias(*)) I(alias(*)) W(alias(*)) D(alias(*)) NOISE(alias(*))
.INC "..\SCHEMATIC1.net"

.END
